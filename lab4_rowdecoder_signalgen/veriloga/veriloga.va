// VerilogA signal generator for 6:64 bit row decoder

`include "constants.vams"
`include "disciplines.vams"

`define ADDRESS_BITS 6

module lab4_rowdecoder_signalgen(addr, en, clk);

// outputs
output [`ADDRESS_BITS-1:0] addr;
output clk;
output en;

// make them continuous voltages
voltage [`ADDRESS_BITS-1:0] addr;
voltage clk;
voltage en;

localparam cp = 6000p;
localparam cp2 = 3000p;

// 64 tests in the testbench
localparam tb = 64;

// clk constants
real clk_sig;
parameter real clk_period = cp from (0:inf);
parameter real clk_period2 = cp2 from (0:inf);
parameter real trise = 20p from [0:inf];
parameter real tfall = 20p from [0:inf];

// voltage constants
parameter real v_high = 1.2;
parameter real v_low  = 0.0;

// integer variables for signal generator outputs
integer addr_cur;
integer en_cur;

// # of tests completed
integer cur_test_count = 0;

// loop counters
genvar j;

// begin analog description
analog begin
    @(initial_step) begin
        addr_cur = 0;
        en_cur   = 0;
    end

    // oscillate clk signal
    @(timer(1n, clk_period2)) begin
        if (clk_sig == v_low) begin
            clk_sig = v_high;
        end else begin
            clk_sig = v_low;
        end
    end

    // set clk voltage
    V(clk) <+ transition(clk_sig, 0, trise, tfall);

    @(timer(0.5n,clk_period)) begin
        // begin test case defn
        if (cur_test_count <= tb) begin
        		en_cur = 1;
			addr_cur = cur_test_count;
		end
		cur_test_count = cur_test_count + 1;
    end

    for (j = 0; j < `ADDRESS_BITS; j = j+1) begin
        V(addr[j]) <+ transition(addr_cur & (1 << j) ? v_high : v_low, 0, trise, tfall);
    end
    V(en) <+ transition(en_cur ? v_high : v_low, 0, trise, tfall);
end

endmodule
