// VerilogA for ece4740, lab4_sram_cell_gen, veriloga

`include "constants.vams"
`include "disciplines.vams"

module lab4_sram_test_gen(word, bit, bit_b, q);

output word, bit, bit_b, q;
voltage word, bit, bit_b, q;

parameter real v_high = 1.2;
parameter real v_low = 0.0;

parameter real trise = 20p from [0:inf];
parameter real tfall = 20p from [0:inf];

// Clock period for test cases
localparam cp = 4000p;

// Number of testcases per testsuite
localparam tb1 = 2;
localparam tb2 = 2;

// Constants for clock periods
parameter real	clk_period = cp from (0:inf);

// int vars for sig gen outputs
integer word_curr, bit_curr, bit_b_curr, q_curr;

integer curTestCount = 0;

analog begin

	// Initialize signal generator output values
	@(initial_step) begin
		q_curr = 0;
		bit_curr = 0;
		bit_b_curr = 0;
		word_curr = 0;
	end

	// Timer block to run testcases
	@(timer(0.5n, clk_period)) begin

		// Testsuite 1: Write 0
		curTestCount = curTestCount + 1;
		if (curTestCount <= tb1) begin
			q_curr = 0;
			bit_curr = 0;
			bit_b_curr = 0;
			word_curr = 0;
			if(curTestCount == 1) begin
				word_curr = 1;
			end
		end

		// Testsuite 2: Write 1
		if (tb1 < curTestCount && curTestCount <= tb1 + tb2) begin
			q_curr = 1;
			bit_curr = 1;
			bit_b_curr = 0;
			word_curr = 0;
			if(curTestCount == tb1 + 1) begin
				word_curr = 1;
			end
		end

	end

	// Set outputs
	V(word) <+ transition(word_curr ? v_high : v_low, trise, tfall);
	V(bit) <+ transition(bit_curr ? v_high : v_low, trise, tfall);
	V(bit_b) <+ transition(bit_b_curr ? v_high : v_low, trise, tfall);
	V(q) <+ transition(q_curr ? v_high : v_low, trise, tfall);

end

endmodule
